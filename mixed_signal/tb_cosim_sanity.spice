** SPDX-FileCopyrightText: 2026 Davide Schiavone
** SPDX-License-Identifier: Apache-2.0 WITH SHL-2.1
**
** Cosim sanity check (no analog yet): fll_digital RTL loaded into ngspice via the
** d_cosim XSPICE code model. Drive clk/reset/code as digital; check dac_code_o
** tracks code_i, and that the divider toggles fout when ro_clk runs.
** code_i set to 2 (expect dac_code_o = 2 after reset).

.param VDD=1.5

* --- digital block (Verilator-built shared lib) ---
a1 [ clk rstn roclk c3 c2 c1 c0 ] [ d3 d2 d1 d0 fout ] fll_digital
.model fll_digital d_cosim simulation="./fll_digital.so" delay=0

* --- stimulus (analog sources -> auto adc_bridge -> digital inputs) ---
Vclk  clk   0 PULSE(0 {VDD} 0 0.1n 0.1n 9.9n 20n)            ; 50 MHz ref clock
Vrstn rstn  0 PWL(0 0 30n 0 31n {VDD})                       ; release reset at 31 ns
Vro   roclk 0 PULSE(0 {VDD} 0 0.1n 0.1n 2n 5n)              ; 200 MHz "RO" stand-in
* code = 2  -> bits c3 c2 c1 c0 = 0 0 1 0
Vc3 c3 0 0
Vc2 c2 0 0
Vc1 c1 0 {VDD}
Vc0 c0 0 0

* --- force dac bridges on the digital outputs so we can probe them as analog ---
Cd3 d3 0 1f
Cd2 d2 0 1f
Cd1 d1 0 1f
Cd0 d0 0 1f
Cfo fout 0 1f

.control
pre_set auto_bridge_d_in =
+ ( ".model auto_adc adc_bridge(in_low='0.4*1.5' in_high='0.6*1.5' rise_delay=1e-11 fall_delay=1e-11)"
+   "auto_bridge%d [ %s ] [ %s ] auto_adc" )
pre_set auto_bridge_d_out =
+ ( ".model auto_dac dac_bridge(out_low=0 out_high=1.5 t_rise=1e-11 t_fall=1e-11)"
+   "auto_bridge%d [ %s ] [ %s ] auto_dac" )
tran 0.05n 100n
* sample dac_code_o bits well after reset release
meas tran vd0 FIND v(d0) AT=90n
meas tran vd1 FIND v(d1) AT=90n
meas tran vd2 FIND v(d2) AT=90n
meas tran vd3 FIND v(d3) AT=90n
echo "dac_code_o bits (d3 d2 d1 d0) at 90ns -> expect 0 0 1 0 for code=2"
set filetype=ascii
write tb_cosim_sanity.raw v(clk) v(d0) v(d1) v(d2) v(d3) v(fout)
.endc
.end
