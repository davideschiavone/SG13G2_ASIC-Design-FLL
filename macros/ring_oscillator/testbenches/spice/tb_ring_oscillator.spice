** SPDX-FileCopyrightText: 2026 Davide Schiavone
** SPDX-License-Identifier: Apache-2.0 WITH SHL-2.1
**
** Ring-oscillator characterization: sweep an IDEAL bias current and measure the
** oscillation frequency. (The real DAC replaces this ideal source later.)
** ihp-sg13g2, schematic-level, SPICE-only.

.lib cornerMOSlv.lib mos_tt

.include ../../spice/ring_oscillator.spice

.param VDDV=1.5

* Supply ramps from 0 -> VDDV over 0.2us to guarantee oscillator start-up.
VDD VDD 0 PWL(0 0 0.2u {VDDV})
VSS VSS 0 0

* Ideal bias current injected into 'nbias' (stands in for the DAC).
Iref VDD nbias DC 8u

Xro VDD VSS nbias clk ring_oscillator

* --- Startup symmetry-breaker (thermal-noise stand-in) ---
* SPICE has no thermal noise, so a perfectly symmetric, noiseless ring sits at its mid-rail
* metastable point forever. On silicon, thermal noise (and power-up asymmetry) starts it.
* A tiny, brief current kick on ONE ring node breaks the symmetry; once the loop gain (>1)
* takes over it grows to full swing. 1uA*1ns (~0.3 mV on a ~4 fF node) is a deliberate
* over-estimate of that noise — the loop actually starts from a perturbation >1000x smaller
* (verified down to 1 nA*2 ns in PEX), i.e. there is ample startup margin. Without this the
* low-bias corner (2 uA) fails to start in sim — a TB artifact, not a design defect.
Ikick VSS Xro.n1 PULSE(0 1u 0.25u 0.1n 0.1n 1n 1)

.control
  set wr_singlescale
  echo "Ibias_uA   freq_MHz"
  foreach ib 2u 4u 8u 16u 31u
    alter Iref dc=$ib
    tran 0.05n 1.5u 0 0.05n uic
    * 20 periods in steady state (well past the 0.2us start-up ramp -> full VDD)
    meas tran t20 TRIG v(clk) VAL=0.75 RISE=20 TARG v(clk) VAL=0.75 RISE=40
    let freq_mhz = 20.0/t20/1e6
    echo "  $ib  ->  $&freq_mhz MHz"
  end
.endc

.end
