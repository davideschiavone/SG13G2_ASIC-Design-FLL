** SPDX-FileCopyrightText: 2026 Davide Schiavone
** SPDX-License-Identifier: Apache-2.0 WITH SHL-2.1
**
** Combined DAC + ring-oscillator characterization (SPICE-only, no mixed-signal yet).
** The voltage sources Vb0..Vb3 PRETEND TO BE fll_digital: they drive the 4-bit DAC
** code. The DAC current sets the ring-oscillator bias -> we measure code -> frequency
** end to end. ihp-sg13g2, schematic-level.

.lib cornerMOSlv.lib mos_tt

.include ../../spice/ring_oscillator.spice
.include ../../../dac/spice/dac4.spice

.param VDDV=1.5

* Supply ramps from 0 -> VDDV over 0.2us to guarantee oscillator start-up.
VDD VDD 0 PWL(0 0 0.2u {VDDV})
VSS VSS 0 0

* Digital code bits (driven by the controller in the real chip); set per-code below.
Vb0 b0 0 DC 0
Vb1 b1 0 DC 0
Vb2 b2 0 DC 0
Vb3 b3 0 DC 0

* DAC drives the ring-oscillator bias node; RO produces clk.
Xdac VDD VSS b0 b1 b2 b3 nbias dac4
Xro  VDD VSS nbias clk ring_oscillator

.control
  set wr_singlescale
  echo "code   freq_MHz"
  foreach code 1 4 8 15
    let cv = $code
    let c1 = floor(cv/2)
    let c2 = floor(cv/4)
    let c3 = floor(cv/8)
    let v0 = (cv - 2*c1) * 1.5
    let v1 = (c1 - 2*c2) * 1.5
    let v2 = (c2 - 2*c3) * 1.5
    let v3 = (c3 - 2*floor(cv/16)) * 1.5
    alter Vb0 = $&v0
    alter Vb1 = $&v1
    alter Vb2 = $&v2
    alter Vb3 = $&v3
    tran 0.05n 1.5u 0 0.05n uic
    * measure 20 periods in steady state (well past the 0.2us start-up ramp)
    meas tran t20 TRIG v(clk) VAL=0.75 RISE=20 TARG v(clk) VAL=0.75 RISE=40
    let freq_mhz = 20.0/t20/1e6
    echo "  $code  ->  $&freq_mhz MHz"
  end
.endc

.end
